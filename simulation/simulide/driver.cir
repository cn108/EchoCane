* EchoCane vibration-motor driver - supplementary transient simulation
* This models the electrical driver, not tactile output.
*
* VCC -- Rmotor -- Lmotor -- Q1 collector
* Q1 emitter -- GND, Q1 base -- Rb -- D6 PWM source
* R2 is the 10 kOhm base pull-down. D1 is the flyback diode across the motor
* (cathode to VCC).
*
* The GPIO is deliberately not an ideal 5 V source. Microchip's ATmega328P
* datasheet guarantees VOH >= 4.2 V at IOH = -20 mA and VCC = 5 V over
* -40 to +85 C. The actual pin current here is about 11 mA; using 4.2 V at that
* lower current is conservative. Finite GPIO output resistance is not modelled:
* the constant 4.2 V source is a DC worst-case approximation, not a datasheet
* curve fit.
*
* The motor is a lumped 47 ohm / 10 mH load, representing about 100 mA at 5 V.
* Component models are generic first-order models, not manufacturer SPICE
* models. Results are indicative, not a substitute for bench measurement.

.option TEMP=25

.param VOH=4.2
.param RBASE=270
.param RPULLDOWN=10k

VCC  vcc 0 DC 5
VDRIVE drive 0 PULSE(0 {VOH} 0 1u 1u 20m 50m)

VSENSE_R1 drive r1in 0
RB r1in base {RBASE}
VSENSE_R2 base r2top 0
R2 r2top 0 {RPULLDOWN}
VSENSE_B base qbase 0
Q1 collector qbase 0 QN2222

RMOT vcc motor 47
LMOT motor motor_return 10m
VSENSE motor_return collector 0

D1 diode_anode vcc D1N4007
VSENSE_D collector diode_anode 0

.model QN2222 NPN(Is=1e-14 Bf=100 Vaf=100 Ikf=0.3 Rb=10 Rc=0.1 Re=0.1
+ Cjc=8p Cje=25p Tf=0.4n Tr=50n)

.model D1N4007 D(Is=7.02e-9 N=1.8 Rs=0.04 Cjo=25p M=0.45 Vj=0.7
+ Fc=0.5 Bv=1000 Ibv=5e-6 Tt=5e-6)

.control
run
set wr_singlescale
wrdata driver-waveform.txt v(drive) v(base) v(collector) v(qbase) i(VSENSE) i(VSENSE_D)
meas tran drive_loaded_avg AVG v(drive) FROM=10m TO=19m
* Currents are reported with ngspice's element sign; the sign is stated in the
* results table. A positive i(VSENSE_B) flows into the Q1 base.
meas tran r1_current_avg AVG i(VSENSE_R1) FROM=10m TO=19m
meas tran r2_current_avg AVG i(VSENSE_R2) FROM=10m TO=19m
meas tran ib_avg AVG i(VSENSE_B) FROM=10m TO=19m
meas tran vbe_avg AVG v(base) FROM=10m TO=19m
meas tran vce_avg AVG v(collector) FROM=10m TO=19m
meas tran motor_current_avg AVG i(VCC) FROM=10m TO=19m
meas tran vcc_avg AVG v(vcc) FROM=10m TO=19m
meas tran vce_peak MAX v(collector) FROM=19m TO=25m
meas tran supply_peak MIN i(VCC) FROM=10m TO=19m
quit
.endc

.tran 10u 120m 0 10u UIC
.end
